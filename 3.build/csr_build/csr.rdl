// SPDX-FileCopyrightText: 2026 Chili.CHIPS*ba
//
// SPDX-License-Identifier: BSD-3-Clause

//========================================================================== 
// Wireguard-1GE FPGA * NLnet-sponsored open-source implementation   
//--------------------------------------------------------------------------
//                   Copyright (C) 2026 Chili.CHIPS*ba
// 
// Redistribution and use in source and binary forms, with or without 
// modification, are permitted provided that the following conditions 
// are met:
//
// 1. Redistributions of source code must retain the above copyright 
// notice, this list of conditions and the following disclaimer.
//
// 2. Redistributions in binary form must reproduce the above copyright 
// notice, this list of conditions and the following disclaimer in the 
// documentation and/or other materials provided with the distribution.
//
// 3. Neither the name of the copyright holder nor the names of its 
// contributors may be used to endorse or promote products derived
// from this software without specific prior written permission.
//
// THIS SOFTWARE IS PROVIDED BY THE COPYRIGHT HOLDERS AND CONTRIBUTORS "AS 
// IS" AND ANY EXPRESS OR IMPLIED WARRANTIES, INCLUDING, BUT NOT LIMITED 
// TO, THE IMPLIED WARRANTIES OF MERCHANTABILITY AND FITNESS FOR A 
// PARTICULAR PURPOSE ARE DISCLAIMED. IN NO EVENT SHALL THE COPYRIGHT 
// HOLDER OR CONTRIBUTORS BE LIABLE FOR ANY DIRECT, INDIRECT, INCIDENTAL, 
// SPECIAL, EXEMPLARY, OR CONSEQUENTIAL DAMAGES (INCLUDING, BUT NOT 
// LIMITED TO, PROCUREMENT OF SUBSTITUTE GOODS OR SERVICES; LOSS OF USE, 
// DATA, OR PROFITS; OR BUSINESS INTERRUPTION) HOWEVER CAUSED AND ON ANY 
// THEORY OF LIABILITY, WHETHER IN CONTRACT, STRICT LIABILITY, OR TORT 
// (INCLUDING NEGLIGENCE OR OTHERWISE) ARISING IN ANY WAY OUT OF THE USE 
// OF THIS SOFTWARE, EVEN IF ADVISED OF THE POSSIBILITY OF SUCH DAMAGE.
//
//              https://opensource.org/license/bsd-3-clause
//--------------------------------------------------------------------------
// Description:
//   This file defines the Control and Status Registers (CSR)
//==========================================================================

addrmap csr {
   name = "csr";
   desc = "WireGuard FPGA CSR";

   littleendian;
   default accesswidth = 32;
   default regwidth = 32;
   default alignment = 4;
   addressing = compact;

   regfile cpu_fifo {
      name = "csr.cpu_fifo";
      desc = "CPU FIFOs CSR";

      regfile rx {
         name = "csr.cpu_fifo.rx";
         desc = "Rx FIFO CSR (CPU --> DPE)";

         reg {
            name = "csr.cpu_fifo.rx.data_31_0";
            desc = "Rx FIFO Data Register";

            field {
               name = "csr.cpu_fifo.rx.data_31_0.tdata[31:0]";
               desc = "1st 4-byte segment of TDATA, i.e. TDATA[31:0]";
               sw = rw;
               hw = r;
            } tdata[32] = 0;
         } data_31_0;

         reg {
            name = "csr.cpu_fifo.rx.data_63_32";
            desc = "Rx FIFO Data Register";

            field {
               name = "csr.cpu_fifo.rx.data_63_32.tdata[31:0]";
               desc = "2nd 4-byte segment of TDATA, i.e. TDATA[63:32]";
               sw = rw;
               hw = r;
            } tdata[32] = 0;
         } data_63_32;

         reg {
            name = "csr.cpu_fifo.rx.data_95_64";
            desc = "Rx FIFO Data Register";

            field {
               name = "csr.cpu_fifo.rx.data_95_64.tdata[31:0]";
               desc = "3rd 4-byte segment of TDATA, i.e. TDATA[95:64]";
               sw = rw;
               hw = r;
            } tdata[32] = 0;
         } data_95_64;

         reg {
            name = "csr.cpu_fifo.rx.data_127_96";
            desc = "Rx FIFO Data Register";

            field {
                name = "csr.cpu_fifo.rx.data_127_96.tdata[31:0]";
               desc = "4th 4-byte segment of TDATA, i.e. TDATA[127:96]";
               sw = rw;
               hw = r;
            } tdata[32] = 0;
         } data_127_96;

         reg {
            name = "csr.cpu_fifo.rx.control";
            desc = "Rx FIFO Control Register";

            field {
               name = "csr.cpu_fifo.rx.control.tkeep[15:0]";
               desc = "Byte-enable for TDATA (e.g. TKEEP[15] corresponds to TDATA[127:119])";
               sw = rw;
               hw = r;
            } tkeep[31:16] = 0;

            field {
               name = "csr.cpu_fifo.rx.control.tlast";
               desc = "Indicates boundary of a packet, i.e. active on last transfer";
               sw = rw;
               hw = r;
            } tlast[15:15] = 0;

            field {
               name = "csr.cpu_fifo.rx.control.tuser_bypass_all";
               desc = "DPE is bypassed when active";
               sw = rw;
               hw = r;
            } tuser_bypass_all[7:7] = 0;

            field {
               name = "csr.cpu_fifo.rx.control.tuser_bypass_stage";
               desc = "Next stage of the DPE is bypassed when active";
               sw = rw;
               hw = r;
            } tuser_bypass_stage[6:6] = 0;

            field {
               name = "csr.cpu_fifo.rx.control.tuser_src[2:0]";
               desc = "Internal source address (0 - CPU, 1 - eth1, 2 - eth2, 3 - eth3, 4 - eth4)";
               sw = rw;
               hw = r;
            } tuser_src[5:3] = 0;

            field {
               name = "csr.cpu_fifo.rx.control.tuser_dst[2:0]";
               desc = "Internal destination address (0 - CPU, 1 - eth1, 2 - eth2, 3 - eth3, 4 - eth4, 7 - broadcast)";
               sw = rw;
               hw = r;
            } tuser_dst[2:0] = 0;
         } control;

         reg {
            name = "csr.cpu_fifo.rx.trigger";
            desc = "Rx FIFO Trigger Register";

            field {
               name = "csr.cpu_fifo.rx.trigger.tvalid";
               desc = "Indicates valid transfer from the CPU to the Rx FIFO (single pulse trigger)";
               singlepulse = true;
               sw = rw;
               hw = r;
            } tvalid = 0;
         } trigger;

         reg {
            name = "csr.cpu_fifo.rx.status";
            desc = "Rx FIFO Status Register";

            field {
               name = "csr.cpu_fifo.rx.status.tready";
               desc = "Indicates that the Rx FIFO can accept a transfer";
               sw = r;
               hw = w;
            } tready = 0;
         } status;
      } rx;

      regfile tx {
         name = "csr.cpu_fifo.tx";
         desc = "Tx FIFO CSR (DPE --> CPU)";

         reg {
            name = "csr.cpu_fifo.tx.data_31_0";
            desc = "Tx FIFO Data Register";

            field {
               name = "csr.cpu_fifo.tx.data_31_0.tdata[31:0]";
               desc = "1st 4-byte segment of TDATA, i.e. TDATA[31:0]";
               sw = r;
               hw = w;
            } tdata[32] = 0;
         } data_31_0;

         reg {
            name = "csr.cpu_fifo.tx.data_63_32";
            desc = "Tx FIFO Data Register";

            field {
               name = "csr.cpu_fifo.tx.data_63_32.tdata[31:0]";
               desc = "2nd 4-byte segment of TDATA, i.e. TDATA[63:32]";
               sw = r;
               hw = w;
            } tdata[32] = 0;
         } data_63_32;

         reg {
            name = "csr.cpu_fifo.tx.data_95_64";
            desc = "Tx FIFO Data Register";

            field {
               name = "csr.cpu_fifo.tx.data_95_64.tdata[31:0]";
               desc = "3rd 4-byte segment of TDATA, i.e. TDATA[95:64]";
               sw = r;
               hw = w;
            } tdata[32] = 0;
         } data_95_64;

         reg {
            name = "csr.cpu_fifo.tx.data_127_96";
            desc = "Tx FIFO Data Register";

            field {
               name = "csr.cpu_fifo.tx.data_127_96.tdata[31:0]";
               desc = "4th 4-byte segment of TDATA, i.e. TDATA[127:96]";
               sw = r;
               hw = w;
            } tdata[32] = 0;
         } data_127_96;

         reg {
            name = "csr.cpu_fifo.tx.control";
            desc = "Tx FIFO Control Register";

            field {
               name = "csr.cpu_fifo.tx.control.tkeep[15:0]";
               desc = "Byte-enable for TDATA (e.g. TKEEP[15] corresponds to TDATA[127:119])";
               sw = r;
               hw = w;
            } tkeep[31:16] = 0;

            field {
               name = "csr.cpu_fifo.tx.control.tlast";
               desc = "Indicates boundary of a packet, i.e. active on last transfer";
               sw = r;
               hw = w;
            } tlast[15:15] = 0;

            field {
               name = "csr.cpu_fifo.tx.control.tuser_bypass_all";
               desc = "If active, DPE was bypassed";
               sw = r;
               hw = w;
            } tuser_bypass_all[7:7] = 0;

            field {
               name = "csr.cpu_fifo.tx.control.tuser_bypass_stage";
               desc = "If active, last stage of the DPE was bypassed";
               sw = r;
               hw = w;
            } tuser_bypass_stage[6:6] = 0;

            field {
               name = "csr.cpu_fifo.tx.control.tuser_src[2:0]";
               desc = "Internal source address (0 - CPU, 1 - eth1, 2 - eth2, 3 - eth3, 4 - eth4)";
               sw = r;
               hw = w;
            } tuser_src[5:3] = 0;

            field {
               name = "csr.cpu_fifo.tx.control.tuser_dst[2:0]";
               desc = "Internal destination address (0 - CPU, 1 - eth1, 2 - eth2, 3 - eth3, 4 - eth4, 7 - broadcast)";
               sw = r;
               hw = w;
            } tuser_dst[2:0] = 0;
         } control;

         reg {
            name = "csr.cpu_fifo.tx.trigger";
            desc = "Tx FIFO Trigger Register";

            field {
               name = "csr.cpu_fifo.tx.trigger.tready";
               desc = "Indicates that the CPU can accept a transfer";
               singlepulse = true;
               sw = rw;
               hw = r;
            } tready = 0;
         } trigger;

         reg {
            name = "csr.cpu_fifo.tx.status";
            desc = "Tx FIFO Status Register";

            field {
               name = "csr.cpu_fifo.tx.status.tvalid";
               desc = "Indicates valid transfer from the Tx FIFO to the CPU";
               sw = r;
               hw = w;
            } tvalid = 0;
         } status;
      } tx;
   } cpu_fifo;

   regfile uart {
      name = "csr.uart";
      desc = "UART CSR";

      reg {
         name = "csr.uart.rx";
         desc = "UART Rx Register";

         field {
            name = "csr.uart.rx.valid";
            desc = "Indicates valid data transfer from the UART to the CPU";
            sw = r;
            hw = w;
         } valid[31:31] = 0;

         field {
            name = "csr.uart.rx.oflow";
            desc = "Indicates that some data bytes are lost";
            sw = r;
            hw = w;
         } oflow[30:30] = 0;

         field {
            name = "csr.uart.rx.data[7:0]";
            desc = "Received data";
            sw = r;
            hw = w;
            swacc = true;
         } data[7:0] = 0;
      } rx;

      reg {
         name = "csr.uart.rx_trigger";
         desc = "UART Rx Trigger Register";

         field {
            name = "csr.uart.rx_trigger.read";
            desc = "Indicates that the CPU can accept next data transfer, used internally - don't try to read or write!";
         } read = 0;
      } rx_trigger;

      rx_trigger.read->next = rx.data->swacc;

      reg {
         name = "csr.uart.tx";
         desc = "UART Tx Register";

         field {
            name = "csr.uart.tx.busy";
            desc = "Indicates that UART cannot accept next data transfer";
            sw = r;
            hw = w;
         } busy[31:31] = 0;

         field {
            name = "csr.uart.tx.data[7:0]";
            desc = "Data to send";
            sw = rw;
            hw = r;
            swmod = true;
         } data[7:0] = 0;
      } tx;

      reg {
         name = "csr.uart.tx_trigger";
         desc = "UART Tx Trigger Register";

         field {
            name = "csr.uart.tx_trigger.write";
            desc = "Indicates valid data transfer from the CPU to the UART, used internally - don't try to read or write!";
         } write = 0;
      } tx_trigger;

      tx_trigger.write->next = tx.data->swmod;
   } uart;

   reg {
      name = "csr.gpio";
      desc = "GPIO Register";

      field {
         name = "csr.gpio.led2";
         desc = "Output to LED2 (0 - off, 1 - on)";
         sw = rw;
         hw = r;
      } led2[9:9] = 0;

      field {
         name = "csr.gpio.led1";
         desc = "Output to LED1 (0 - off, 1 - on)";
         sw = rw;
         hw = r;
      } led1[8:8] = 0;

      field {
         name = "csr.gpio.key2";
         desc = "Input from KEY2 (0 - not pressed, 1 - pressed)";
         sw = r;
         hw = w;
      } key2[1:1] = 0;

      field {
         name = "csr.gpio.key1";
         desc = "Input from KEY1 (0 - not pressed, 1 - pressed)";
         sw = r;
         hw = w;
      } key1[0:0] = 0;
   } gpio;

   regfile ethernet {
      name = "csr.ethernet[0..3]";
      desc = "Ethernet CSR";

      reg {
         name = "csr.ethernet[0..3].status";
         desc = "Ethernet Status Register";

         field {
            name = "csr.ethernet[0..3].status.speed[1:0]";
            desc = "Indicates the established link speed on a particular Ethernet interface (0 - 10 Mbps, 1 - 100 Mbps, 2 - 1000 Mbps)";
            sw = r;
            hw = w;
         } speed[1:0] = 0;
      } status;

      reg {
         name = "csr.ethernet[0..3].mac_47_32";
         desc = "Ethernet Interface MAC Address";

         field {
            name = "csr.ethernet[0..3].mac_47_32.mac[15:0]";
            desc = "Ethernet Interface MAC Address (upper word)";
            sw = rw;
            hw = r;
         } mac[15:0] = 0;
      } mac_47_32;

      reg {
         name = "csr.ethernet[0..3].mac_31_0";
         desc = "Ethernet Interface MAC Address";

         field {
            name = "csr.ethernet[0..3].mac_31_0.mac[31:0]";
            desc = "Ethernet Interface MAC Address (lower word)";
            sw = rw;
            hw = r;
         } mac[31:0] = 0;
      } mac_31_0;
   } ethernet[4];

   reg {
      name = "csr.hw_id";
      desc = "Hardware IDs";

      field {
         name = "csr.hw_id.VENDOR";
         desc = "Vendor ID";
         sw = r;
         hw = r;
      } VENDOR[31:16] = 0xCCBA;

      field {
         name = "csr.hw_id.PRODUCT";
         desc = "Product ID";
         sw = r;
         hw = r;
      } PRODUCT[15:0] = 0xCACA;
   } hw_id;

   reg {
      name = "csr.hw_version";
      desc = "Hardware Version";

      field {
         name = "csr.hw_version.MAJOR";
         desc = "Major version";
         sw = r;
         hw = r;
      } MAJOR[31:24] = 0x01;

      field {
         name = "csr.hw_version.MINOR";
         desc = "Minor version";
         sw = r;
         hw = r;
      } MINOR[23:16] = 0x00;

      field {
         name = "csr.hw_version.PATCH";
         desc = "Patch version";
         sw = r;
         hw = r;
      } PATCH[15:0] = 0x0000;
   } hw_version;

   regfile dpe {
      name = "csr.dpe";
      desc = "Data Plane Engine CSR";

      reg {
         name = "csr.dpe.fcr";
         desc = "DPE Flow Control Register";

         field {
            name = "csr.dpe.fcr.pause";
            desc = "Pauses DPE";
            sw = rw;
            hw = r;
         } pause[1:1] = 0;

         field {
            name = "csr.dpe.fcr.idle";
            desc = "1: the multiplexer has stopped (pause) and the switch holds no packet that still reads the tables, so the routing and cryptokey tables and wg_ip/wg_port can be written. Packets past the switch (demultiplexer, Ethernet TX) may still be on their way: they no longer read the tables. An Ethernet port that does not send can hold the switch, and so this bit, at 0";
            sw = r;
            hw = w;
         } idle[0:0] = 0;
      } fcr;

      reg {
         name = "csr.dpe.wg_port";
         desc = "WireGuard UDP listen port: the disassembler takes IPv4 UDP packets to this port as WireGuard";

         field {
            name = "csr.dpe.wg_port.port";
            desc = "UDP port number (default 51820)";
            sw = rw;
            hw = r;
         } port[15:0] = 51820;
      } wg_port;

      reg {
         name = "csr.dpe.wg_ip";
         desc = "This device's WireGuard address: the disassembler takes IPv4 UDP packets to wg_ip:wg_port as WireGuard for this device; WireGuard to other addresses passes through. 0 (the reset value) until the firmware sets it";

         field {
            name = "csr.dpe.wg_ip.ip";
            desc = "IPv4 address";
            sw = rw;
            hw = r;
         } ip[31:0] = 0;
      } wg_ip;
   } dpe;

   reg {
      name = "csr.cycle";
      desc = "Free-running clock cycle counter: counts system clock cycles since reset and wraps at 2^32. The firmware reads it instead of rdcycle, which eduBOS5 does not have";

      field {
         name = "csr.cycle.count";
         desc = "System clock cycles since reset";
         sw = r;
         hw = na;
         counter;
      } count[31:0] = 0;
   } cycle;

   external regfile routing_table {
      name = "csr.routing_table";
      desc = "Routing Table";

      regfile entry {
         name = "csr.routing_table.entry[0..63]";
         desc = "Routing Table Entry";

         reg {
            name = "csr.routing_table.entry[0..63].ip";
            desc = "IP Address";

            field {
               name = "csr.routing_table.entry[0..63].ip.ip[31:0]";
               sw = rw;
               hw = r;
            } ip[31:0];
         } ip;

         reg {
            name = "csr.routing_table.entry[0..63].mask";
            desc = "Subnet Mask";

            field {
               name = "csr.routing_table.entry[0..63].mask.mask[31:0]";
               sw = rw;
               hw = r;
            } mask[31:0];
         } mask;

         reg {
            name = "csr.routing_table.entry[0..63].peer_idx";
            desc = "WireGuard Peer Index";

            field {
               name = "csr.routing_table.entry[0..63].peer_idx.peer_idx[5:0]";
               sw = rw;
               hw = r;
            } peer_idx[5:0];

            field {
               name = "csr.routing_table.entry[0..63].peer_idx.encrypt";
               desc = "1: the route goes through the WireGuard tunnel to peer_idx (the encryptor encrypts its packets); 0: its packets go out as they are";
               sw = rw;
               hw = r;
            } encrypt[8:8] = 0;
         } peer_idx;

         reg {
            name = "csr.routing_table.entry[0..63].dst";
            desc = "Destination Interface";

            field {
               name = "csr.routing_table.entry[0..63].dst.dst[2:0]";
               sw = rw;
               hw = r;
            } dst[2:0];
         } dst;
      } entry[64];
   } routing_table @ 0x0400;

   external regfile cryptokey_table {
      name = "csr.cryptokey_table";
      desc = "Cryptokey Table";

      regfile entry {
         name = "csr.cryptokey_table.entry[0..63]";
         desc = "Cryptokey Table Entry";

         reg {
            name = "csr.cryptokey_table.entry[0..63].local_mac_47_32";
            desc = "Local Ethernet Interface MAC Address";

            field {
               name = "csr.cryptokey_table.entry[0..63].local_mac_47_32.mac[15:0]";
               desc = "Local Ethernet Interface MAC Address (upper word)";
               sw = rw;
               hw = r;
            } mac[15:0] = 0;
         } local_mac_47_32;

         reg {
            name = "csr.cryptokey_table.entry[0..63].local_mac_31_0";
            desc = "Local Ethernet Interface MAC Address";

            field {
               name = "csr.cryptokey_table.entry[0..63].local_mac_31_0.mac[31:0]";
               desc = "Local Ethernet Interface MAC Address (lower word)";
               sw = rw;
               hw = r;
            } mac[31:0] = 0;
         } local_mac_31_0;

         reg {
            name = "csr.cryptokey_table.entry[0..63].local_ip";
            desc = "Local IP Address";

            field {
               name = "csr.cryptokey_table.entry[0..63].local_ip.ip[31:0]";
               sw = rw;
               hw = r;
            } ip[31:0];
         } local_ip;

         reg {
            name = "csr.cryptokey_table.entry[0..63].local_port";
            desc = "Local UDP Port";

            field {
               name = "csr.cryptokey_table.entry[0..63].local_port.port[15:0]";
               sw = rw;
               hw = r;
            } port[15:0];
         } local_port;

         reg {
            name = "csr.cryptokey_table.entry[0..63].local_id";
            desc = "Local ID";

            field {
               name = "csr.cryptokey_table.entry[0..63].local_id.id[31:0]";
               sw = rw;
               hw = r;
            } id[31:0];
         } local_id;

         reg {
            name = "csr.cryptokey_table.entry[0..63].remote_mac_47_32";
            desc = "Remote Ethernet Interface MAC Address";

            field {
               name = "csr.cryptokey_table.entry[0..63].remote_mac_47_32.mac[15:0]";
               desc = "Remote Ethernet Interface MAC Address (upper word)";
               sw = rw;
               hw = r;
            } mac[15:0] = 0;
         } remote_mac_47_32;

         reg {
            name = "csr.cryptokey_table.entry[0..63].remote_mac_31_0";
            desc = "Remote Ethernet Interface MAC Address";

            field {
               name = "csr.cryptokey_table.entry[0..63].remote_mac_31_0.mac[31:0]";
               desc = "Remote Ethernet Interface MAC Address (lower word)";
               sw = rw;
               hw = r;
            } mac[31:0] = 0;
         } remote_mac_31_0;

         reg {
            name = "csr.cryptokey_table.entry[0..63].remote_ip";
            desc = "Remote IP Address";

            field {
               name = "csr.cryptokey_table.entry[0..63].remote_ip.ip[31:0]";
               sw = rw;
               hw = r;
            } ip[31:0];
         } remote_ip;

         reg {
            name = "csr.cryptokey_table.entry[0..63].remote_port";
            desc = "Remote UDP Port";

            field {
               name = "csr.cryptokey_table.entry[0..63].remote_port.port[15:0]";
               sw = rw;
               hw = r;
            } port[15:0];
         } remote_port;

         reg {
            name = "csr.cryptokey_table.entry[0..63].remote_id";
            desc = "Remote ID";

            field {
               name = "csr.cryptokey_table.entry[0..63].remote_id.id[31:0]";
               sw = rw;
               hw = r;
            } id[31:0];
         } remote_id;

         reg {
            name = "csr.cryptokey_table.entry[0..63].encrypt_key_255_224";
            desc = "Encryption Key, bits 255:224. The 8 key words hold the 32-byte key as one little-endian 256-bit number: key byte i is bits 8i+7:8i, so this word holds bytes 31 (in [31:24]) to 28, and encrypt_key_31_0 holds bytes 3 to 0 (byte 0 in [7:0]). The same for decrypt_key";

            field {
               name = "csr.cryptokey_table.entry[0..63].encrypt_key_255_224.key[31:0]";
               sw = rw;
               hw = r;
            } key[31:0];
         } encrypt_key_255_224;

         reg {
            name = "csr.cryptokey_table.entry[0..63].encrypt_key_223_192";
            desc = "Encryption Key";

            field {
               name = "csr.cryptokey_table.entry[0..63].encrypt_key_223_192.key[31:0]";
               sw = rw;
               hw = r;
            } key[31:0];
         } encrypt_key_223_192;

         reg {
            name = "csr.cryptokey_table.entry[0..63].encrypt_key_191_160";
            desc = "Encryption Key";

            field {
               name = "csr.cryptokey_table.entry[0..63].encrypt_key_191_160.key[31:0]";
               sw = rw;
               hw = r;
            } key[31:0];
         } encrypt_key_191_160;

         reg {
            name = "csr.cryptokey_table.entry[0..63].encrypt_key_159_128";
            desc = "Encryption Key";

            field {
               name = "csr.cryptokey_table.entry[0..63].encrypt_key_159_128.key[31:0]";
               sw = rw;
               hw = r;
            } key[31:0];
         } encrypt_key_159_128;

         reg {
            name = "csr.cryptokey_table.entry[0..63].encrypt_key_127_96";
            desc = "Encryption Key";

            field {
               name = "csr.cryptokey_table.entry[0..63].encrypt_key_127_96.key[31:0]";
               sw = rw;
               hw = r;
            } key[31:0];
         } encrypt_key_127_96;

         reg {
            name = "csr.cryptokey_table.entry[0..63].encrypt_key_95_64";
            desc = "Encryption Key";

            field {
               name = "csr.cryptokey_table.entry[0..63].encrypt_key_95_64.key[31:0]";
               sw = rw;
               hw = r;
            } key[31:0];
         } encrypt_key_95_64;

         reg {
            name = "csr.cryptokey_table.entry[0..63].encrypt_key_63_32";
            desc = "Encryption Key";

            field {
               name = "csr.cryptokey_table.entry[0..63].encrypt_key_63_32.key[31:0]";
               sw = rw;
               hw = r;
            } key[31:0];
         } encrypt_key_63_32;

         reg {
            name = "csr.cryptokey_table.entry[0..63].encrypt_key_31_0";
            desc = "Encryption Key";

            field {
               name = "csr.cryptokey_table.entry[0..63].encrypt_key_31_0.key[31:0]";
               sw = rw;
               hw = r;
            } key[31:0];
         } encrypt_key_31_0;

         reg {
            name = "csr.cryptokey_table.entry[0..63].decrypt_key_255_224";
            desc = "Decryption Key, bits 255:224: key bytes 31 (in [31:24]) to 28, as encrypt_key_255_224";

            field {
               name = "csr.cryptokey_table.entry[0..63].decrypt_key_255_224.key[31:0]";
               sw = rw;
               hw = r;
            } key[31:0];
         } decrypt_key_255_224;

         reg {
            name = "csr.cryptokey_table.entry[0..63].decrypt_key_223_192";
            desc = "Decryption Key";

            field {
               name = "csr.cryptokey_table.entry[0..63].decrypt_key_223_192.key[31:0]";
               sw = rw;
               hw = r;
            } key[31:0];
         } decrypt_key_223_192;

         reg {
            name = "csr.cryptokey_table.entry[0..63].decrypt_key_191_160";
            desc = "Decryption Key";

            field {
               name = "csr.cryptokey_table.entry[0..63].decrypt_key_191_160.key[31:0]";
               sw = rw;
               hw = r;
            } key[31:0];
         } decrypt_key_191_160;

         reg {
            name = "csr.cryptokey_table.entry[0..63].decrypt_key_159_128";
            desc = "Decryption Key";

            field {
               name = "csr.cryptokey_table.entry[0..63].decrypt_key_159_128.key[31:0]";
               sw = rw;
               hw = r;
            } key[31:0];
         } decrypt_key_159_128;

         reg {
            name = "csr.cryptokey_table.entry[0..63].decrypt_key_127_96";
            desc = "Decryption Key";

            field {
               name = "csr.cryptokey_table.entry[0..63].decrypt_key_127_96.key[31:0]";
               sw = rw;
               hw = r;
            } key[31:0];
         } decrypt_key_127_96;

         reg {
            name = "csr.cryptokey_table.entry[0..63].decrypt_key_95_64";
            desc = "Decryption Key";

            field {
               name = "csr.cryptokey_table.entry[0..63].decrypt_key_95_64.key[31:0]";
               sw = rw;
               hw = r;
            } key[31:0];
         } decrypt_key_95_64;

         reg {
            name = "csr.cryptokey_table.entry[0..63].decrypt_key_63_32";
            desc = "Decryption Key";

            field {
               name = "csr.cryptokey_table.entry[0..63].decrypt_key_63_32.key[31:0]";
               sw = rw;
               hw = r;
            } key[31:0];
         } decrypt_key_63_32;

         reg {
            name = "csr.cryptokey_table.entry[0..63].decrypt_key_31_0";
            desc = "Decryption Key";

            field {
               name = "csr.cryptokey_table.entry[0..63].decrypt_key_31_0.key[31:0]";
               sw = rw;
               hw = r;
            } key[31:0];
         } decrypt_key_31_0;

         reg {
            name = "csr.cryptokey_table.entry[0..63].send_cnt_63_32";
            desc = "Sender Counter";

            field {
               name = "csr.cryptokey_table.entry[0..63].send_cnt_63_32.cnt[31:0]";
               sw = rw;
               hw = rw;
               we;
            } cnt[31:0];
         } send_cnt_63_32;

         reg {
            name = "csr.cryptokey_table.entry[0..63].send_cnt_31_0";
            desc = "Sender Counter";

            field {
               name = "csr.cryptokey_table.entry[0..63].send_cnt_31_0.cnt[31:0]";
               sw = rw;
               hw = rw;
               we;
            } cnt[31:0];
         } send_cnt_31_0;

         reg {
            name = "csr.cryptokey_table.entry[0..63].recv_cnt_63_32";
            desc = "Receiver Counter";

            field {
               name = "csr.cryptokey_table.entry[0..63].recv_cnt_63_32.cnt[31:0]";
               sw = rw;
               hw = rw;
               we;
            } cnt[31:0];
         } recv_cnt_63_32;

         reg {
            name = "csr.cryptokey_table.entry[0..63].recv_cnt_31_0";
            desc = "Receiver Counter";

            field {
               name = "csr.cryptokey_table.entry[0..63].recv_cnt_31_0.cnt[31:0]";
               sw = rw;
               hw = rw;
               we;
            } cnt[31:0];
         } recv_cnt_31_0;
      } entry[64] += 0x80;  // 30 words, padded to 32: entry = addr[12:7], word = addr[6:2]
   } cryptokey_table @ 0x2000;
};

addrmap wireguard {
   littleendian;
   default accesswidth = 32;
   default regwidth = 32;
   default alignment = 4;
   addressing = compact;

   external mem imem {
      name = "imem";
      desc = "CPU Program Memory";
      mementries = 16384;
      memwidth = 32;
   } imem @ 0x0000_0000;

   external mem dmem {
      name = "dmem";
      desc = "CPU Data Memory";
      mementries = 16384;
      memwidth = 32;
   } dmem @ 0x1000_0000;

   csr csr @ 0x2000_0000;
};

// -----------------------------------------------------------------------------
// Project:     WireGuard-FPGA
// Description: NLnet-funded open-source implementation
// Funding:     https://nlnet.nl/project/KlusterLab-Wireguard (2023-12 to 2025-12)
// -----------------------------------------------------------------------------
